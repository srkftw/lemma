PCM voltage driver coil and motional RLC functional bench
* SPDX-License-Identifier: Apache-2.0
* Editable passive electrical equivalent only: no measured transducer, acoustic
* pressure, onset, tissue transmission, contact-force or safety qualification.
Vpcm pcm 0 PWL(0 0 100u 0 101u 0.1 600u 0.1 601u -0.1 1.1m -0.1 1.101m 0.15 1.6m 0.15 1.601m 0 2.1m 0 2.101m 0.12 2.6m 0.12 2.601m -0.12 3.1m -0.12 3.101m 0.1 8m 0.1)
Venable enabled 0 PWL(0 1 3.25m 1 3.250001m 0 8m 0)
* B source is a functional bounded-gain driver, not a transistor-level IC.
Bdriver drive 0 V=2*V(pcm)*V(enabled)
Rdriver drive coil 2
Lcoil coil winding 1m
Rcoil winding displacement 8
Cmotional displacement 0 10u
.tran 1u 8m 0 1u
.control
set wr_singlescale
set wr_vecnames
run
wrdata bone-driver.dat v(pcm) v(drive) v(displacement) i(Lcoil) v(enabled)
quit
.endc
.end
